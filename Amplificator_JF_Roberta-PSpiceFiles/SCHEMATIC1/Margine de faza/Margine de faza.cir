** Profile: "SCHEMATIC1-Margine de faza"  [ c:\users\roberta\onedrive\desktop\p1_2025_434d_ambrozie_ioana-roberta_aaf_n4_pspice\p1_2025_434d_ambrozie_ioana-roberta_aaf_n4_pspice\schematics\proiect cef roberta\amplificator_jf_roberta-pspicefiles\schematic1\margine de faza.sim ]

** Creating circuit file "Margine de faza.cir"
** WARNING: THIS AUTOMATICALLY GENERATED FILE MAY BE OVERWRITTEN BY SUBSEQUENT SIMULATIONS

*Libraries:
* Profile Libraries :
* Local Libraries :
.LIB "c:/users/roberta/onedrive/desktop/lib_modelepspice_anexa_1/modele_a1_lib/1n4148.lib"
.LIB "c:/users/roberta/onedrive/desktop/lib_modelepspice_anexa_1/modele_a1_lib/bc807-25.lib"
.LIB "c:/users/roberta/onedrive/desktop/lib_modelepspice_anexa_1/modele_a1_lib/bc817-25.lib"
.LIB "c:/users/roberta/onedrive/desktop/lib_modelepspice_anexa_1/modele_a1_lib/bc846b.lib"
.LIB "c:/users/roberta/onedrive/desktop/lib_modelepspice_anexa_1/modele_a1_lib/bc856b.lib"
.LIB "c:/users/roberta/onedrive/desktop/lib_modelepspice_anexa_1/modele_a1_lib/bzx84c2v7.lib"
.LIB "c:/users/roberta/onedrive/desktop/lib_modelepspice_anexa_1/modele_a1_lib/bzx84c5v1.lib"
.LIB "c:/users/roberta/onedrive/desktop/lib_modelepspice_anexa_1/modele_a1_lib/bzx84c5v6.lib"
.LIB "c:/users/roberta/onedrive/desktop/lib_modelepspice_anexa_1/modele_a1_lib/bzx84c6v2.lib"
.LIB "c:/users/roberta/onedrive/desktop/lib_modelepspice_anexa_1/modele_a1_lib/bzx84c6v8.lib"
.LIB "c:/users/roberta/onedrive/desktop/lib_modelepspice_anexa_1/modele_a1_lib/bzx84c8v2.lib"
.LIB "c:/users/roberta/onedrive/desktop/lib_modelepspice_anexa_1/modele_a1_lib/bzx84c10.lib"
.LIB "c:/users/roberta/onedrive/desktop/lib_modelepspice_anexa_1/modele_a1_lib/irfr120npbf.lib"
.LIB "c:/users/roberta/onedrive/desktop/lib_modelepspice_anexa_1/modele_a1_lib/mjd31cg.lib"
.LIB "c:/users/roberta/onedrive/desktop/lib_modelepspice_anexa_1/modele_a1_lib/mjd32cg.lib"
.LIB "c:/users/roberta/onedrive/desktop/lib_modelepspice_anexa_1/modele_a1_lib/mmbfj177lt1g.lib"
.LIB "c:/users/roberta/onedrive/desktop/lib_modelepspice_anexa_1/modele_a1_lib/mmbfj309lt1g.lib"
.LIB "c:/users/roberta/onedrive/desktop/lib_modelepspice_anexa_1/modele_a1_lib/nss30101lt1g.lib"
* From [PSPICE NETLIST] section of D:\Apps\cdssetup\OrCAD_PSpice/16.6.0/PSpice.ini file:
.lib "nomd.lib"

*Analysis directives:
.AC DEC 100 1 100000000
.OPTIONS ADVCONV
.PROBE64 V(alias(*)) I(alias(*)) W(alias(*)) D(alias(*)) NOISE(alias(*))
.INC "..\SCHEMATIC1.net"

.END
